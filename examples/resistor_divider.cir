* CSPICE Example: DC Analysis
* Simple resistor network

* Circuit: Voltage source with resistor divider
V1 1 0 DC 12
R1 1 2 2k
R2 2 0 1k
R3 2 3 500

* Analysis: DC operating point
.analysis dc

* Output: Voltages at nodes 2 and 3
.print v(2)
.print v(3)

.end
