V1 1 0 SIN(0 155100 50 0 0 0)
V2 2 0 SIN(0 155100 50 0 0 -120)
V3 3 0 SIN(0 155100 50 0 0 120)
Rgen1 1 4 100
Rgen2 2 5 100
Rgen3 3 6 100
.MODEL XFMR1 TRSAT (V1_nom=110000 V2_nom=110000 f_nom=50 S_nom=63000000 u_k=0.1 Acore=0.1 lpath=3 Np=700 Bsat=1.5 Mur=1000 Rcore=200 R1=1)
.MODEL XFMR2 TRSAT (V1_nom=110000 V2_nom=110000 f_nom=50 S_nom=63000000 u_k=0.1 Acore=0.1 lpath=3 Np=700 Bsat=1.5 Mur=1000 Rcore=200 R1=1)
.MODEL XFMR3 TRSAT (V1_nom=110000 V2_nom=110000 f_nom=50 S_nom=63000000 u_k=0.1 Acore=0.1 lpath=3 Np=700 Bsat=1.5 Mur=1000 Rcore=200 R1=1)
TRSAT1 4 5 7 0 XFMR1
TRSAT2 5 6 8 0 XFMR2
TRSAT3 6 4 9 0 XFMR3
Rload1 7 0 100
Rload2 8 0 100
Rload3 9 0 100
.ANALYSIS TRAN 50u 1
.PRINT TRAN v(4) i(Rgen1) i_pri(XFMR1) i_pri(XFMR2) i_mag(XFMR1) i_sec(XFMR1)
.WRITE transformer_test.csv
